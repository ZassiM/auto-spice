parameters  eps=17 epsphib=5.5 Ndiscmin=0.008
global 0

subckt my_ckt r0 c0
I0 (r0 c0) JART_VCM_1b_det eps=17 epsphib=5.5 phiBn0=0.18 phin=0.1 un=4e-06 Ndiscmax=20 Ndiscmin=0.008 Ninit=Ndiscmin Nplug=20 a=2.5e-10 ny0=2e+13 dWa=1.35 Rth0=1.8e+7 rdet=45e-9 lcell=3 ldet=0.4 Rtheff_scaling=0.27 RseriesTiOx=650 R0=719.244 Rthline=90471.5 alphaline=0.00392
ends my_ckt
XBAR (r0 c0 ) my_ckt

V0 (r0 0) vsource type=pwl wave=[ 0 0 90u 0 100u 0.2 190u 0.2 200u 0 290u 0 300u -0.75 390u -0.75 400u 0 490u 0 500u 0.2 590u 0.2 600u 0 690u 0 700u 1.5 790u 1.5 800u 0 890u 0 900u 0.2 990u 0.2 1000u 0 1100u 0]

V1 (c0 0) vsource dc=0

save XBAR.I0:OE XBAR.I0:AE
ahdl_include "/net/home/zahr/Documents/Gitlab/auto-spice/deps/JART-memristor-models/JART_VCM_v1b.va"
simulatorOptions options vabstol=1e-6 iabstol=1e-12 temp=27 tnom=27 gmin=1e-12
trans tran stop=1100u errpreset=conservative maxstep=1n
saveOptions options save=all currents=all saveahdlvars=all
