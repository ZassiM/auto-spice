global 0
ahdl_include "C:\Users\wasso\Desktop\HiWi\Gitlab\auto-spice/deps/JART-memristor-models/JART_VCM_v1b.va"
include "C:\Users\wasso\Desktop\HiWi\Gitlab\auto-spice/deps/transistor-models/32nm_HP.pm"
simulatorOptions options vabstol=1e-6 iabstol=1e-12 temp=27 tnom=27 gmin=1e-12
trans tran stop = 700u maxstep = 1u errpreset=conservative
saveOptions options save=all currents=all saveahdlvars=all
parameters Read_V = 0.2 Set_V = 1 Reset_V = -1.5 Gate_V = 1.6

parameters T0 = 0.293 eps = 17 epsphib = 5.5 phiBn0 = 0.18 phin = 0.1 \
		un = 4e-06 Ndiscmax = 20 Ndiscmin = 0.008 Ninit = 0.008 Nplug = 20 \
		a = 2.5e-10 ny0 = 20000000000000.0 dWa = 1.35 Rth0 = 18000000.0 rdet = 4.5e-08 \
		lcell = 3 ldet = 0.4 Rtheff_scaling = 0.27 RseriesTiOx = 650 R0 = 719.244 \
		Rthline = 90471.5 alphaline = 0.00392

subckt TM_subckt MemInput Output TransGate Bulk
	M0 (net MemInput) JART_VCM_1b_det	T0 = T0 eps = eps epsphib = epsphib phiBn0 = phiBn0 phin = phin \
		un = un Ndiscmax = Ndiscmax Ndiscmin = Ndiscmin Ninit = Ninit Nplug = Nplug \
		a = a ny0 = ny0 dWa = dWa Rth0 = Rth0 rdet = rdet \
		lcell = lcell ldet = ldet Rtheff_scaling = Rtheff_scaling RseriesTiOx = RseriesTiOx R0 = R0 \
		Rthline = Rthline alphaline = alphaline
	T0 (net TransGate Output Bulk) nmos
ends TM_subckt

I0 (r0 c0 g0 c0) TM_subckt
I1 (r0 c1 g0 c1) TM_subckt
I2 (r0 c2 g0 c2) TM_subckt
I3 (r1 c0 g1 c0) TM_subckt
I4 (r1 c1 g1 c1) TM_subckt
I5 (r1 c2 g1 c2) TM_subckt

V_WL0(r0 0) vsource type=pwl wave=[\
0u	0	\
99u	0	\
100u	Set_V	\
199u	Set_V	\
200u	0	\
299u	0	\
300u	Reset_V	\
399u	Reset_V	\
400u	0	\
499u	0	\
500u	Read_V	\
599u	Read_V	\
600u	0	\
699u	0	\
]
V_SEL0(g0 0) vsource type=pwl wave=[\
0u	Gate_V	\
99u	Gate_V	\
100u	Gate_V	\
199u	Gate_V	\
200u	Gate_V	\
299u	Gate_V	\
300u	Gate_V	\
399u	Gate_V	\
400u	Gate_V	\
499u	Gate_V	\
500u	Gate_V	\
599u	Gate_V	\
600u	Gate_V	\
699u	Gate_V	\
700u	0	\
799u	0	\
800u	0	\
899u	0	\
]

V_WL1(r1 0) vsource type=pwl wave=[\
700u	0	\
799u	0	\
800u	Read_V	\
899u	Read_V	\
]
V_SEL1(g1 0) vsource type=pwl wave=[\
0u	0	\
99u	0	\
100u	0	\
199u	0	\
200u	0	\
299u	0	\
300u	0	\
399u	0	\
400u	0	\
499u	0	\
500u	0	\
599u	0	\
600u	0	\
699u	0	\
700u	Gate_V	\
799u	Gate_V	\
800u	Gate_V	\
899u	Gate_V	\
]

V_BL0(c0 0) vsource type=pwl wave=[\
0u	0	\
99u	0	\
100u	0	\
199u	0	\
200u	0	\
299u	0	\
300u	Reset_V	\
399u	Reset_V	\
400u	Reset_V	\
499u	Reset_V	\
500u	Read_V	\
599u	Read_V	\
600u	Read_V	\
699u	Read_V	\
700u	0	\
799u	0	\
800u	0	\
899u	0	\
]

V_BL1(c1 0) vsource type=pwl wave=[\
0u	Set_V	\
99u	Set_V	\
100u	Set_V	\
199u	Set_V	\
200u	Set_V	\
299u	Set_V	\
300u	0	\
399u	0	\
400u	0	\
499u	0	\
500u	Read_V	\
599u	Read_V	\
600u	Read_V	\
699u	Read_V	\
700u	Read_V	\
799u	Read_V	\
800u	Read_V	\
899u	Read_V	\
]

V_BL2(c2 0) vsource type=pwl wave=[\
0u	Set_V	\
99u	Set_V	\
100u	Set_V	\
199u	Set_V	\
200u	Set_V	\
299u	Set_V	\
300u	Reset_V	\
399u	Reset_V	\
400u	Reset_V	\
499u	Reset_V	\
500u	0	\
599u	0	\
600u	0	\
699u	0	\
700u	Read_V	\
799u	Read_V	\
800u	Read_V	\
899u	Read_V	\
]
