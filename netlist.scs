global 0
ahdl_include "C:\Users\wasso\Desktop\auto-spice/deps/memristor-models/JART_VCM_v1b.va"
include "C:\Users\wasso\Desktop\auto-spice/deps/transistor-models/32nm_HP.pm"
simulatorOptions options vabstol = 1e-06 iabstol = 1e-12 temp = 27 tnom = 27 gmin = 1e-12
trans tran stop =  1000n maxstep = 1n errpreset=conservative
saveOptions options save=all currents=all saveahdlvars=all
parameters Read_V = 0.3 Set_V = 1 Reset_V = -1.5 Gate_V = 1.3 Transistor_Width = 32n Transistor_Length = 32n
parameters Rth0 = 15720000.0

subckt XBAR_CELL WordLine BitLine SelectLine
	M0 (net WordLine) JART_VCM_1b_det	Rth0 = Rth0
	T0 (net SelectLine BitLine BitLine) nmos  w = Transistor_Width	 l = Transistor_Length
ends XBAR_CELL

I0 (r0 c00 g0) XBAR_CELL
I1 (r0 c01 g0) XBAR_CELL
I2 (r0 c02 g0) XBAR_CELL
I3 (r0 c03 g0) XBAR_CELL
I4 (r1 c10 g1) XBAR_CELL
I5 (r1 c11 g1) XBAR_CELL
I6 (r1 c12 g1) XBAR_CELL
I7 (r1 c13 g1) XBAR_CELL

V_WL0(r0 0) vsource type=pwl wave=[\
0n	0	\
49n	0	\
50n	Set_V	\
149n	Set_V	\
150n	0	\
199n	0	\
200n	Reset_V	\
299n	Reset_V	\
300n	0	\
349n	0	\
350n	0	\
399n	0	\
450n	0	\
499n	0	\
500n	0	\
549n	0	\
600n	0	\
649n	0	\
650n	Read_V	\
749n	Read_V	\
750n	0	\
799n	0	\
800n	Read_V	\
899n	Read_V	\
900n	0	\
949n	0	\
950n	Read_V	\
1049n	Read_V	\
1050n	0	\
1099n	0	\
1100n	Read_V	\
1199n	Read_V	\
1200n	0	\
1249n	0	\
1250n	0	\
1299n	0	\
1350n	0	\
1399n	0	\
1400n	0	\
1449n	0	\
1500n	0	\
1549n	0	\
1550n	0	\
1599n	0	\
1650n	0	\
1699n	0	\
1700n	0	\
1749n	0	\
1800n	0	\
1849n	0	\
]
V_SEL0(g0 0) vsource type=pwl wave=[\
0n	0	\
49n	0	\
50n	Gate_V	\
149n	Gate_V	\
150n	0	\
199n	0	\
200n	Gate_V	\
299n	Gate_V	\
300n	0	\
349n	0	\
450n	0	\
499n	0	\
600n	0	\
649n	0	\
650n	Gate_V	\
749n	Gate_V	\
750n	0	\
799n	0	\
800n	Gate_V	\
899n	Gate_V	\
900n	0	\
949n	0	\
950n	Gate_V	\
1049n	Gate_V	\
1050n	0	\
1099n	0	\
1100n	Gate_V	\
1199n	Gate_V	\
1200n	0	\
1249n	0	\
1350n	0	\
1399n	0	\
1500n	0	\
1549n	0	\
1650n	0	\
1699n	0	\
1800n	0	\
1849n	0	\
]

V_WL1(r1 0) vsource type=pwl wave=[\
0n	0	\
49n	0	\
50n	0	\
99n	0	\
150n	0	\
199n	0	\
200n	0	\
249n	0	\
300n	0	\
349n	0	\
350n	Set_V	\
449n	Set_V	\
450n	0	\
499n	0	\
500n	Reset_V	\
599n	Reset_V	\
600n	0	\
649n	0	\
650n	0	\
699n	0	\
750n	0	\
799n	0	\
800n	0	\
849n	0	\
900n	0	\
949n	0	\
950n	0	\
999n	0	\
1050n	0	\
1099n	0	\
1100n	0	\
1149n	0	\
1200n	0	\
1249n	0	\
1250n	Read_V	\
1349n	Read_V	\
1350n	0	\
1399n	0	\
1400n	Read_V	\
1499n	Read_V	\
1500n	0	\
1549n	0	\
1550n	Read_V	\
1649n	Read_V	\
1650n	0	\
1699n	0	\
1700n	Read_V	\
1799n	Read_V	\
1800n	0	\
1849n	0	\
]
V_SEL1(g1 0) vsource type=pwl wave=[\
0n	0	\
49n	0	\
150n	0	\
199n	0	\
300n	0	\
349n	0	\
350n	Gate_V	\
449n	Gate_V	\
450n	0	\
499n	0	\
500n	Gate_V	\
599n	Gate_V	\
600n	0	\
649n	0	\
750n	0	\
799n	0	\
900n	0	\
949n	0	\
1050n	0	\
1099n	0	\
1200n	0	\
1249n	0	\
1250n	Gate_V	\
1349n	Gate_V	\
1350n	0	\
1399n	0	\
1400n	Gate_V	\
1499n	Gate_V	\
1500n	0	\
1549n	0	\
1550n	Gate_V	\
1649n	Gate_V	\
1650n	0	\
1699n	0	\
1700n	Gate_V	\
1799n	Gate_V	\
1800n	0	\
1849n	0	\
]

V_BL00(c00 0) vsource type=pwl wave=[\
0n	0	\
49n	0	\
50n	0	\
149n	0	\
150n	0	\
199n	0	\
200n	Reset_V	\
299n	Reset_V	\
300n	0	\
349n	0	\
650n	0	\
749n	0	\
750n	0	\
799n	0	\
800n	Read_V	\
899n	Read_V	\
900n	0	\
949n	0	\
950n	Read_V	\
1049n	Read_V	\
1050n	0	\
1099n	0	\
1100n	Read_V	\
1199n	Read_V	\
1200n	0	\
1249n	0	\
]

V_BL01(c01 0) vsource type=pwl wave=[\
0n	0	\
49n	0	\
50n	Set_V	\
149n	Set_V	\
150n	0	\
199n	0	\
200n	0	\
299n	0	\
300n	0	\
349n	0	\
650n	Read_V	\
749n	Read_V	\
750n	0	\
799n	0	\
800n	0	\
899n	0	\
900n	0	\
949n	0	\
950n	Read_V	\
1049n	Read_V	\
1050n	0	\
1099n	0	\
1100n	Read_V	\
1199n	Read_V	\
1200n	0	\
1249n	0	\
]

V_BL02(c02 0) vsource type=pwl wave=[\
0n	0	\
49n	0	\
50n	0	\
149n	0	\
150n	0	\
199n	0	\
200n	Reset_V	\
299n	Reset_V	\
300n	0	\
349n	0	\
650n	Read_V	\
749n	Read_V	\
750n	0	\
799n	0	\
800n	Read_V	\
899n	Read_V	\
900n	0	\
949n	0	\
950n	0	\
1049n	0	\
1050n	0	\
1099n	0	\
1100n	Read_V	\
1199n	Read_V	\
1200n	0	\
1249n	0	\
]

V_BL03(c03 0) vsource type=pwl wave=[\
0n	0	\
49n	0	\
50n	Set_V	\
149n	Set_V	\
150n	0	\
199n	0	\
200n	0	\
299n	0	\
300n	0	\
349n	0	\
650n	Read_V	\
749n	Read_V	\
750n	0	\
799n	0	\
800n	Read_V	\
899n	Read_V	\
900n	0	\
949n	0	\
950n	Read_V	\
1049n	Read_V	\
1050n	0	\
1099n	0	\
1100n	0	\
1199n	0	\
1200n	0	\
1249n	0	\
]

V_BL10(c10 0) vsource type=pwl wave=[\
0n	0	\
49n	0	\
350n	Set_V	\
449n	Set_V	\
450n	0	\
499n	0	\
500n	0	\
599n	0	\
600n	0	\
649n	0	\
1250n	0	\
1349n	0	\
1350n	0	\
1399n	0	\
1400n	Read_V	\
1499n	Read_V	\
1500n	0	\
1549n	0	\
1550n	Read_V	\
1649n	Read_V	\
1650n	0	\
1699n	0	\
1700n	Read_V	\
1799n	Read_V	\
1800n	0	\
1849n	0	\
]

V_BL11(c11 0) vsource type=pwl wave=[\
0n	0	\
49n	0	\
350n	0	\
449n	0	\
450n	0	\
499n	0	\
500n	Reset_V	\
599n	Reset_V	\
600n	0	\
649n	0	\
1250n	Read_V	\
1349n	Read_V	\
1350n	0	\
1399n	0	\
1400n	0	\
1499n	0	\
1500n	0	\
1549n	0	\
1550n	Read_V	\
1649n	Read_V	\
1650n	0	\
1699n	0	\
1700n	Read_V	\
1799n	Read_V	\
1800n	0	\
1849n	0	\
]

V_BL12(c12 0) vsource type=pwl wave=[\
0n	0	\
49n	0	\
350n	Set_V	\
449n	Set_V	\
450n	0	\
499n	0	\
500n	0	\
599n	0	\
600n	0	\
649n	0	\
1250n	Read_V	\
1349n	Read_V	\
1350n	0	\
1399n	0	\
1400n	Read_V	\
1499n	Read_V	\
1500n	0	\
1549n	0	\
1550n	0	\
1649n	0	\
1650n	0	\
1699n	0	\
1700n	Read_V	\
1799n	Read_V	\
1800n	0	\
1849n	0	\
]

V_BL13(c13 0) vsource type=pwl wave=[\
0n	0	\
49n	0	\
350n	0	\
449n	0	\
450n	0	\
499n	0	\
500n	Reset_V	\
599n	Reset_V	\
600n	0	\
649n	0	\
1250n	Read_V	\
1349n	Read_V	\
1350n	0	\
1399n	0	\
1400n	Read_V	\
1499n	Read_V	\
1500n	0	\
1549n	0	\
1550n	Read_V	\
1649n	Read_V	\
1650n	0	\
1699n	0	\
1700n	0	\
1799n	0	\
1800n	0	\
1849n	0	\
]
