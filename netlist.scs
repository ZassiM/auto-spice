global 0
ahdl_include "C:\Users\wasso\Desktop\auto-spice/deps/memristor-models/JART_VCM_v1b.va"
include "C:\Users\wasso\Desktop\auto-spice/deps/transistor-models/32nm_HP.pm"
simulatorOptions options vabstol = 1e-06 iabstol = 1e-12 temp = 27 tnom = 27 gmin = 1e-12
trans tran stop =  4100u maxstep = 1u errpreset=conservative
saveOptions options save=all currents=all saveahdlvars=all
parameters Read_V = 0.3 Set_V = 1 Reset_V = -1.5 Gate_V = 1.3 Transistor_Width = 32n Transistor_Length = 32n
parameters Rth0 = 15720000.0

subckt XBAR_CELL WordLine BitLine SelectLine
	M0 (net WordLine) JART_VCM_1b_det	Rth0 = Rth0
	T0 (net SelectLine BitLine BitLine) nmos  w = Transistor_Width	 l = Transistor_Length
ends XBAR_CELL

I0 (r0 c0 g0) XBAR_CELL
I1 (r0 c1 g0) XBAR_CELL
I2 (r1 c0 g1) XBAR_CELL
I3 (r1 c1 g1) XBAR_CELL

V_WL0(r0 0) vsource type=pwl wave=[\
0u	0	\
49u	0	\
50u	Read_V	\
1049u	Read_V	\
1050u	0	\
1099u	0	\
2050u	Set_V	\
3049u	Set_V	\
3050u	0	\
3099u	0	\
4050u	Read_V	\
5049u	Read_V	\
5050u	0	\
5099u	0	\
6050u	Set_V	\
7049u	Set_V	\
7050u	0	\
7099u	0	\
7100u	0	\
8099u	0	\
8100u	0	\
9099u	0	\
9100u	0	\
10099u	0	\
10100u	0	\
11099u	0	\
]
V_SEL0(g0 0) vsource type=pwl wave=[\
0u	0	\
49u	0	\
50u	Gate_V	\
1049u	Gate_V	\
1050u	0	\
1099u	0	\
2050u	Gate_V	\
3049u	Gate_V	\
3050u	0	\
3099u	0	\
4050u	Gate_V	\
5049u	Gate_V	\
5050u	0	\
5099u	0	\
6050u	Gate_V	\
7049u	Gate_V	\
7050u	0	\
7099u	0	\
8100u	0	\
8149u	0	\
10100u	0	\
10149u	0	\
]

V_WL1(r1 0) vsource type=pwl wave=[\
0u	0	\
49u	0	\
50u	0	\
1049u	0	\
1050u	0	\
2049u	0	\
2050u	0	\
3049u	0	\
3050u	0	\
4049u	0	\
4050u	0	\
5049u	0	\
5050u	0	\
6049u	0	\
6050u	0	\
7049u	0	\
7050u	0	\
8049u	0	\
7100u	Read_V	\
8099u	Read_V	\
8100u	0	\
8149u	0	\
9100u	Set_V	\
10099u	Set_V	\
10100u	0	\
10149u	0	\
]
V_SEL1(g1 0) vsource type=pwl wave=[\
0u	0	\
49u	0	\
1050u	0	\
1099u	0	\
3050u	0	\
3099u	0	\
5050u	0	\
5099u	0	\
7050u	0	\
7099u	0	\
7100u	Gate_V	\
8099u	Gate_V	\
8100u	0	\
8149u	0	\
9100u	1.5	\
10099u	1.5	\
10100u	0	\
10149u	0	\
]

V_BL0(c0 0) vsource type=pwl wave=[\
0u	0	\
49u	0	\
50u	0	\
1049u	0	\
1050u	0	\
1099u	0	\
2050u	0	\
3049u	0	\
3050u	0	\
3099u	0	\
4050u	Read_V	\
5049u	Read_V	\
5050u	0	\
5099u	0	\
6050u	Set_V	\
7049u	Set_V	\
7050u	0	\
7099u	0	\
7100u	0	\
8099u	0	\
8100u	0	\
8149u	0	\
9100u	0	\
10099u	0	\
10100u	0	\
10149u	0	\
]

V_BL1(c1 0) vsource type=pwl wave=[\
0u	0	\
49u	0	\
50u	Read_V	\
1049u	Read_V	\
1050u	0	\
1099u	0	\
2050u	Set_V	\
3049u	Set_V	\
3050u	0	\
3099u	0	\
4050u	0	\
5049u	0	\
5050u	0	\
5099u	0	\
6050u	0	\
7049u	0	\
7050u	0	\
7099u	0	\
7100u	Read_V	\
8099u	Read_V	\
8100u	0	\
8149u	0	\
9100u	Set_V	\
10099u	Set_V	\
10100u	0	\
10149u	0	\
]
