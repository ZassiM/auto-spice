// Design: memristor_testbench/4x4_1T1M
simulator lang=spectre
global 0
parameters col0ReadDelay=75n col0ReadFall=500p col0ReadPeriod=150n col0ReadPulseWidth=40n col0ReadRise=500p col0ReadV=0.5 col0ResetDelay=150n col0ResetFall=500p col0ResetPeriod=300n col0ResetPulseWidth=40n col0ResetRise=500p col0ResetV=-2 col0SetDealy=0 col0SetFall=500p col0SetPeriod=300n col0SetPuseWidth=40n col0SetRise=500p col0SetV=2 col1ReadDelay=0 col1ReadFall=500p col1ReadPeriod=0 col1ReadPulseWidth=0 col1ReadRise=500p col1ReadV=0 col1ResetDelay=0 col1ResetFall=500p col1ResetPeriod=0 col1ResetPulseWidth=0 col1ResetRise=500p col1ResetV=0 col1SetDealy=0 col1SetFall=500p col1SetPeriod=0 col1SetPuseWidth=0 col1SetRise=500p col1SetV=0 r0Delay=0 r0Fall=500p r0Per=75n r0Pulse=40n r0Ris=500p r1Delay=0 r1Fall=500p r1Per=0 r1Pulse=0 r1Ris=500p TranV=0.5
include "/net/home/alindari/LAlindari/mosfet/90nm_bulk.pm"

// memristor_lib/1T1M/schematic
subckt memristor_lib_1T1M_schematic MemInput Output TransGate inh_bulk_n
parameters Ninit
    I0 (net03 MemInput) JART_VCM_1b_det T0=0.293 eps=17 epsphib=5.5 phiBn0=0.18 phin=0.1 un=4e-06 Ndiscmax=20 Ndiscmin=0.008 Ninit=Ninit Nplug=20 a=2.5e-10 ny0=2e+13 dWa=1.35 Rth0=1.572e+07 rdet=4.5e-08 lcell=3 ldet=0.4 Rtheff_scaling=0.27 RseriesTiOx=650 R0=719.244 Rthline=90471.5 alphaline=0.00392
    M0 (net03 TransGate Output inh_bulk_n) nmos
ends memristor_lib_1T1M_schematic

// memristor_lib/ReadWriteCircuit/schematic
subckt ReadWriteCircuit Pulse Ground
parameters ResetV ResetPeriod ResetDealy ResetRise ResetFall ResetPulseWidth SetV SetPeriod SetDealy SetRise SetFall SetPulseWidth ReadPeriod ReadDealy ReadRise ReadFall ReadPulseWidth ReadV
    W2 (ResetV Pulse net012 Ground) relay vt1=0 vt2=2 ropen=1T rclosed=1m
    W0 (SetV Pulse net013 Ground) relay vt1=0 vt2=2 ropen=1T rclosed=1m
    W1 (ReadV Pulse net6 Ground) relay vt1=0 vt2=2 ropen=1T rclosed=1m
    V9 (ResetV Ground) vsource type=pulse val0=0 val1=ResetV period=ResetPeriod delay=ResetDealy rise=ResetRise fall=ResetFall width=ResetPulseWidth
    V10 (net012 Ground) vsource type=pulse val0=0 val1=2 period=ResetPeriod delay=ResetDealy rise=ResetRise fall=ResetFall width=ResetPulseWidth
    V8 (SetV Ground) vsource type=pulse val0=0 val1=SetV period=SetPeriod delay=SetDealy rise=SetRise fall=SetFall width=SetPulseWidth
    V6 (net013 Ground) vsource type=pulse val0=0 val1=2 period=SetPeriod delay=SetDealy rise=SetRise fall=SetFall width=SetPulseWidth
    V68 (net6 Ground) vsource type=pulse val0=0 val1=2 period=ReadPeriod delay=ReadDealy rise=ReadRise fall=ReadFall width=ReadPulseWidth
    V5 (ReadV Ground) vsource type=pulse val0=0 val1=ReadV period=ReadPeriod delay=ReadDealy rise=ReadRise fall=ReadFall width=ReadPulseWidth
ends ReadWriteCircuit

// memristor_testbench/4x4_1T1M/schematic
I20 (col3 0 r3 0) memristor_lib_1T1M_schematic Ninit=1000
I19 (col2 0 r3 0) memristor_lib_1T1M_schematic Ninit=1000
I18 (col3 0 r2 0) memristor_lib_1T1M_schematic Ninit=1000
I17 (col2 0 r2 0) memristor_lib_1T1M_schematic Ninit=0.008
I16 (col1 0 r3 0) memristor_lib_1T1M_schematic Ninit=1000
I15 (col0 0 r3 0) memristor_lib_1T1M_schematic Ninit=1000
I14 (col1 0 r2 0) memristor_lib_1T1M_schematic Ninit=1000
I13 (col0 0 r2 0) memristor_lib_1T1M_schematic Ninit=0.008
I12 (col3 0 r1 0) memristor_lib_1T1M_schematic Ninit=1000
I11 (col2 0 r1 0) memristor_lib_1T1M_schematic Ninit=1000
I10 (col3 0 r0 0) memristor_lib_1T1M_schematic Ninit=1000
I9 (col2 0 r0 0) memristor_lib_1T1M_schematic Ninit=0.008
I3 (col1 0 r1 0) memristor_lib_1T1M_schematic Ninit=1000
I2 (col0 0 r1 0) memristor_lib_1T1M_schematic Ninit=1000
I1 (col1 0 r0 0) memristor_lib_1T1M_schematic Ninit=1000
I0 (col0 0 r0 0) memristor_lib_1T1M_schematic Ninit=0.008

I22 (col3 net25) ReadWriteCircuit ResetV=col1ResetV ResetPeriod=col1ResetPeriod ResetDealy=col1ResetDelay ResetRise=col1ResetRise ResetFall=col1ResetFall ResetPulseWidth=col1ResetPulseWidth SetV=col1SetV SetPeriod=col1SetPeriod SetDealy=col1SetDealy SetRise=col1SetRise SetFall=col1SetFall SetPulseWidth=col1SetPuseWidth ReadPeriod=col1ReadPeriod ReadDealy=col1ReadDelay ReadRise=col1ReadRise ReadFall=col1ReadFall ReadPulseWidth=col1ReadPulseWidth ReadV=col1ReadV
I21 (col2 net26) ReadWriteCircuit ResetV=col1ResetV ResetPeriod=col1ResetPeriod ResetDealy=col1ResetDelay ResetRise=col1ResetRise ResetFall=col1ResetFall ResetPulseWidth=col1ResetPulseWidth SetV=col1SetV SetPeriod=col1SetPeriod SetDealy=col1SetDealy SetRise=col1SetRise SetFall=col1SetFall SetPulseWidth=col1SetPuseWidth ReadPeriod=col1ReadPeriod ReadDealy=col1ReadDelay ReadRise=col1ReadRise ReadFall=col1ReadFall ReadPulseWidth=col1ReadPulseWidth ReadV=col1ReadV
I8 (col0 net27) ReadWriteCircuit ResetV=col0ResetV ResetPeriod=col0ResetPeriod ResetDealy=col0ResetDelay ResetRise=col0ResetRise ResetFall=col0ResetFall ResetPulseWidth=col0ResetPulseWidth SetV=col0SetV SetPeriod=col0SetPeriod SetDealy=col0SetDealy SetRise=col0SetRise SetFall=col0SetFall SetPulseWidth=col0SetPuseWidth ReadPeriod=col0ReadPeriod ReadDealy=col0ReadDelay ReadRise=col0ReadRise ReadFall=col0ReadFall ReadPulseWidth=col0ReadPulseWidth ReadV=col0ReadV
I6 (col1 net28) ReadWriteCircuit ResetV=col1ResetV ResetPeriod=col1ResetPeriod ResetDealy=col1ResetDelay ResetRise=col1ResetRise ResetFall=col1ResetFall ResetPulseWidth=col1ResetPulseWidth SetV=col1SetV SetPeriod=col1SetPeriod SetDealy=col1SetDealy SetRise=col1SetRise SetFall=col1SetFall SetPulseWidth=col1SetPuseWidth ReadPeriod=col1ReadPeriod ReadDealy=col1ReadDelay ReadRise=col1ReadRise ReadFall=col1ReadFall ReadPulseWidth=col1ReadPulseWidth ReadV=col1ReadV

V9 (r3 0) vsource type=pulse val0=0 val1=TranV period=r1Per delay=r1Delay rise=r1Ris fall=r1Fall width=r1Pulse
V7 (r2 0) vsource type=pulse val0=0 val1=TranV period=r1Per delay=r1Delay rise=r1Ris fall=r1Fall width=r1Pulse
V2 (r0 0) vsource type=pulse val0=0 val1=TranV period=r0Per delay=r0Delay rise=r0Ris fall=r0Fall width=r0Pulse
V3 (r1 0) vsource type=pulse val0=0 val1=TranV period=r1Per delay=r1Delay rise=r1Ris fall=r1Fall width=r1Pulse
simulatorOptions options temp=27
tran tran stop=1.4u errpreset=conservative
save I0:1
ahdl_include "/net/home/zahr/Documents/neurosimulationplayground/memristor_lib/memristor_model/veriloga/veriloga.va"
