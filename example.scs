simulator lang=spectre
global 0
parameters VGATE=1 VSET=1

VGate (Gate 0) vsource type=pwl delay=0 wave=[ 0 0 1n 1 10n 1 11n VGATE 1u VGATE 5
1.001u 1]

VOE (OE 0) vsource type=pwl delay=0 wave=[ 0 0 1n 0.3 10n 0.3 11n VSET 1u VSET 6
1.001u 0.3 ]

ReRAM (AE OE) JART_VCM_1b_det
T (AE Gate 0 0) ptm_32nmHP_bulk_nmos w=32n l=32n

swp sweep param=VGATE values=[0.5 0.7 0.9 1.1 1.3]{ 10
tran tran stop=2u errpreset=conservative maxstep=1e-8 11
}

saveOptions options save=all currents=all saveahdlvars=all
ahdl_include "veriloga.va"
include "transistor_modelfile"
