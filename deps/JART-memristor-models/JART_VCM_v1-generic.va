// JART VCM1 compact model
// This model has been published in the following paper
// [1] A. Siemon, D. J. Wouters, S. Hamdioui and S. Menzel
// "Memristive Device Modeling and Circuit Design Exploration for Computation-in-Memory"
// 2019 IEEE International Symposium on Circuits and Systems (ISCAS), Sapporo, Japan, 26-29 May, 2019
// In this model, the equations of [1] are referenced and the nomenclature of [1] is used with the only difference that the SET and RESET polarity is switched.
// This model has a SET at a negative voltage and a RESET at a positive voltage. Therefore equation 3 in [1] now is valid for V > 0 and equation 5 is valid for V < 0.
// If this model is used for publications it should be referenced in the form:
// The simulations were performed using the JART VCM v1 c model [1]. The simulation parameters are given in table xx.

// Last updated on 17.02.2020
// For inquires please contact jart@iwe.rwth-aachen.de

`include "constants.vams"
`include "disciplines.vams"

module JART_VCM_1_generic(BE,TE);

	inout BE,TE;
	electrical BE,TE,plug_ser,gnd,schottky_disc,disc_plug,ion,Tion;
	ground gnd;

//	physical constants do not change
	localparam e 	= 1.602e-19;									// elementary charge [C]
	localparam kb	= 1.3807e-23;								// Boltzman's constant  [VAs/K]
	localparam Arichardson  = 6.01e5;								// Richardson's constant [A/m^2K^2]
	localparam pi 		  = 3.1416; 								// Pi
	localparam mstar		  = 9.10938e-31;			  				// electron rest mass [kg]
	localparam h		  	  = 6.626e-34; 							// Planck's constant [Js]
	localparam zvo		  = 2;									// oxygen vacancy charge number
	localparam eps_0	= 8.854e-12;				      				// vacuum permittivity [As/Vm]

// fitting parameters
	parameter real A 	= 2.8274e-15 ;							// cross sectional filament area (cylindrical filament) [m^2]
	parameter real ldisc 	= 4;										// length of the disc region [nm]
	parameter real lcell	= 6;										// length of disc and plug region [nm]
	parameter real epsphib	  =  5.5;							// permittivity related to image force barrier lowering
	parameter real eps	= 21.46; 								// static oxide permittivity
	parameter real Nmax	= 10;									// maximum oxygen vacancy concentration in the disc [10^26/m^3]
	parameter real a	= 0.4e-9;									// ion hopping distance [m]
	parameter real ny0	= 1e14;									// attempt frequenzy [Hz]
	parameter real Nplug = 25;									// oxygen vacancy concentration in the plug [10^26/m^3]
	parameter real un	= 9.4e-6;								// electron mobility [m^2/Vs]
	parameter real phin  	= 0.1;									// energy level difference between the Fermi level in the oxide and the oxide conduction band edge [eV]
	parameter real phiBn0 	= 0.8;								// nominal schottky barrier height [eV]
	parameter real T0 	= 300;									// ambient temperature [K]
	parameter real RS	= 1160;									// series resistance [Ohm]
	parameter real Ninit 	= 0.9;									// initial oxygen vacancy concentration in the disc [10^26/m^3]
	parameter real Nmin	= 0.9;									// minimum oxygen vacancy concentration in the disc [10^26/m^3]
	parameter real Rth	= 6.9e5;									// thermal resistance of the Hafnium Oxide [W/K]
	parameter real dWa	= 0.6;									// activation energy [eV]

	real phiB,psi,W00,W0,xi,c,Ndisc,Nchange,eps_eff,epsphib_eff,E;

	analog
		begin
////////////////////////////////////////////////////////
// auxiliary variables							   //
////////////////////////////////////////////////////////
eps_eff=eps*eps_0;
epsphib_eff=epsphib*eps_0;

////////////////////////////////////////////////////////
// equivalent circuit diagramm 					   //
////////////////////////////////////////////////////////

// local temperature in the filament here only used for the ionic current part
V(Tion,gnd)<+(V(BE,plug_ser)*I(disc_plug,plug_ser)*Rth+T0)/1000; // Equation 3

if (V(BE,schottky_disc)<phiBn0-phin)
	begin
		psi=phiBn0-phin-V(BE,schottky_disc);
		phiB=phiBn0-sqrt(sqrt(pow(e,3)*zvo*Ndisc*1e26*psi/(8*pow(pi,2)*(pow(epsphib_eff,3)))));		// Equation 7
		if (phiB<0)
			phiB=0;
	end
else
	begin
		psi=0;
		phiB=phiBn0;
end

if (V(BE,schottky_disc)<0)	// SET direction (thermionic field emission)
	begin
		W00=e*h/(4*pi)*sqrt(zvo*Ndisc*1e26/(mstar*eps_eff));	// Equation 8
		W0=W00/tanh(W00/kb/T0);	// Equation 9
		xi=W00/(W00/kb/T0-tanh(W00/kb/T0));		// Equation 10
		I(BE,schottky_disc)<+-A*Arichardson*T0/kb*sqrt(pi*W00*e*(abs(V(BE,schottky_disc))+phiB/pow(cosh(W00/(kb*T0)),2)))*exp(-e*phiB/W0)*(exp(e*abs(V(BE,schottky_disc))/xi)-1);		// Equation 6
	end
else		//RESET direction thermal emission
	begin
		I(BE,schottky_disc)<+A*Arichardson*pow(T0,2)*exp(-phiB*e/(kb*T0))*(exp(e/(kb*T0)*V(BE,schottky_disc))-1);		// Equation 5
	end

// Disc Resistance
V(schottky_disc,disc_plug)<+I(schottky_disc,disc_plug)*ldisc*1e-9/(Ndisc*1e26*zvo*e*un*A);	// Equation 12

// Plug Resistance
V(disc_plug,plug_ser)<+I(disc_plug,plug_ser)*(lcell-ldisc)*1e-9/(Nplug*1e26*zvo*e*un*A);		// Equation 11

// Series Resistance
V(plug_ser,TE)<+RS*I(plug_ser,TE);

////////////////////////////////////////////////////////
// Solve ODE 									   //
////////////////////////////////////////////////////////

// calculation of the concentration
Nchange=idt(-V(ion,gnd)/(A*ldisc*1e-9*e*zvo*1e26),0);	// Equation 1
Ndisc=Ninit+Nchange;

// I_ion is realised through a voltage source here
if (((Ndisc<Nmin)&(V(BE,plug_ser)>0))|((Ndisc>Nmax)&(V(BE,plug_ser)<0)))
	begin
		V(ion,gnd)<+0;
	end
else
	begin
		c = (Nplug+Ndisc)*1e26/2;
		if (V(BE,plug_ser)>0)
			begin
				E=V(BE,plug_ser)/(lcell*1e-9);		// Equation 4
			end
		else
			begin
				E=V(schottky_disc,disc_plug)/(ldisc*1e-9);		// Equation 4
			end
		V(ion,gnd)<+zvo*e*c*a*ny0*A*exp(-dWa*e/(kb*V(Tion,gnd)*1000))*sinh(zvo*a*e*E/(2*kb*1000*V(Tion,gnd)));	// Equation 2
	end

	end
endmodule
