// JART VCM1 compact model for Random Telegraph noise (RTN)
// This model has been published in the following papers
// [1] Stefan Wiefels, Christopher Bengel, Nils Kopperberg, Kaihua Zhang, Rainer Waser and Stephan Menzel
// "HRS Instability in Oxide-Based Bipolar Resistive Switching Cells"
// IEEE TRANSACTIONS ON ELECTRON DEVICES, VOL. 67, NO. 10, OCTOBER 2020
// doi:10.1109/TED.2020.3018096
// and [2] C. Bengel, A. Siemon, F. Cueppers, Susanne Hofmann-Eifert, Alexander Hardtdegen, Moritz von Witzleben, Lena Hellmich, Rainer Waser and Stephan Menzel
// "Variability-Aware" Modeling of Filamentary Oxide-Based Bipolar Resistive Switching Cells Using SPICE Level Compact Models"
// IEEE Transactions on Circuits and Systems-I Regular Papers, VOL. 67, NO. 12, December 2020
// doi:10.1109/TCSI.2020.3018502
// In this model, the equations of [2] are referenced and the nomenclature of [2] is used. The descrition of the Read Noise Module is found in [1].
// The model was further extended by a thermal capacity (cth).
// If this model is used for publications it should be referenced in the form:
// The simulations were performed using the JART VCM v1b Read Variability model [1, 2]. The simulation parameters are given in table xx.

// Last updated on 01.02.2021
// For inquires please contact jart@iwe.rwth-aachen.de
// the modified fitting parameter is lcell which was changed to 5 nm (ZrOx stack) instead of 3 nm (HOTO stack) and ldisc is 0.6 instead of 0.4
`include "constants.vams"
`include "disciplines.vams"

module JART_VCM_v1b_ReadVar( AE, OE );

	inout AE,OE;
	electrical trackNnoisechange,slopeN,AE,be,OE,gnd,N,T,schottkytunnel,resistorR0,ion,Thop;//,slopeVAE,isSETN,isSETR,trackRread,trackGread,trackNdiscmax,trackNdiscmin,trackrvar,trackrold,trackrnew,tracklvar,tracklold,tracklnew;
	ground gnd;

	//Electric branches.
	branch (AE,schottkytunnel) schottky;
	branch (schottkytunnel,OE) discplugserial;

//  physical constants do not change!
	localparam Arichardson  = 6.01e5;								// Richardson's constant [A/m^2K^2]
	localparam mdiel		  = 9.10938e-31;			  				// electron rest mass [kg]
	localparam zvo		  = 2;									// oxygen vacancy charge number

//  fitting parameters
	parameter real eps	= 17 from [10:25]; 							// static hafnium oxide permittivity
	parameter real epsphib	  =  5.5;								// hafnium oxide permittivity related to image force barrier lowering
	parameter real phibn0 	= 0.18 from [0.1:0.5];						// nominal schottky barrier height [eV]
	parameter real phin  	= 0.1	from [0.1:0.3];						// energy level difference between the Fermi level in the oxide and the oxide conduction band edge [eV]
	parameter real un	= 4e-6	from [1e-6:1e-5];					// electron mobility [m^2/Vs]
	parameter real Ndiscmax	= 20	 from [0.1:1000];					// maximum oxygen vacancy concentration in the disc[10^26/m^3]
	parameter real Ndiscmin	= 8e-3 from [4e-3:0.1];				// minimum oxygen vacancy concentration in the disc [10^26/m^3]
	parameter real Ninit =8e-3 from [5e-4:1000];									// initial oxygen vacancy concentration in the disc [10^26/m^3]
	parameter real Nplug = 20 from [0.1:1000];										// oxygen vacancy concentration in the plug [10^26/m^3]
	parameter real a	= 0.25e-9 from [0.1e-9:1e-9];						// ion hopping distance [m]
	parameter real nyo	= 2e13 from [1e10:1e14];						// attemp frequenzy [Hz]
	parameter real dWa	= 1.35 from [0.8:1.5];							// activation energy [eV]
	parameter real Rth0  = 15.72e6 from [1e6:20e6];					// thermal resistance of the Hafnium Oxide [K/W]
	parameter real rdet = 45e-9 	from [5e-9:100e-9];					// radius of the filament [m]
	parameter real rnew = 45e-9 from [5e-9:100e-9];					// radius of the filament [m]
	parameter real lcell	= 5	from [2:5];								// length of disc and plug region [nm]
	parameter real ldet 	= 0.6 	from [0.1:5]; 							// length of the disc region [nm]
	parameter real lnew 	= 0.6 	from [0.1:5]; 							// length of the disc region [nm]
	parameter real Rtheff_scaling = 0.27 from [0.1:1]; 				// scaling factor for RESET
	parameter real RTiOx = 650 from [0:5000]; 					// series resistance [Ohm]
	parameter real R0 = 719.2437;										//  Resistance at T0 [Ohm}
	parameter real Rthline = 90471.47;									// thermal conductivity of the Platinum and Titanium [W/mK]
	parameter real alphaline = 3.92e-3;									// temperature coefficient [1/K]

	real Ischottkytunnel,Flim,A,phibn,Rtheff,psi,W00,W0,epsprime,cvo,Treal,Nreal,Nchange,E_ion,dWamin,dWamax,gamma,Rdisc,Rplug,Rseries,rvar,lvar,lold,Nold,rold;

	parameter real eps_eff=eps*`P_EPS0; // static hafnium oxide permittivity
	parameter real epsphib_eff=epsphib*`P_EPS0; // hafnium oxide permittivity related to image force barrier lowering

	//Thermal branch for temperature calculation
	thermal t;
	branch (t) rth_branch;
	branch (t) ith_branch;
	parameter real cth = 1e-18;

//Noise implementation
	real Nnoise_change=0; //Parameters with random values for ionic and electric noise
	real p1,p2,p3;				//Probability for the jumps

// jump frequency evaluation
	integer numberzeros=0;
	integer numberplusones=0;
	integer numberplustwos=0;
	integer numberminusones=0;
	integer numberminustwos=0;

//Jump implementation
//	parameter integer order = 10000;
	integer jump;					// current jump
	integer jump_old=0;				//previous jump
	integer Nnoise_init;
	real p_jump,p_jump_2;				//respective randomnumbers between 0 and 1
	real randnum_jump,randnum_jump2;
	real freq;
	integer	uniqueseed;

	analog
		begin

@(initial_step)
begin
	rvar=rnew;
	lvar=lnew;
	lold=lnew;
	rold=rnew;
	Nold=Ninit;
	Nreal=Ninit;
	Treal=$temperature;

	//Creating Jump Distribution
	p1 =0.1; //calc_poiss_cdf(1,poisson_lambda); //p1 = 0.0915 (matlab X=2 is VerilogA X=1)
	p2 = 0.4; //calc_poiss_cdf(2,poisson_lambda); //p2 = 0.238 calc_poiss_cdf(random number, lambda)
	p3 = 0.45;//calc_poiss_cdf(3,poisson_lambda); //p3 = 0.433
	uniqueseed=$random;
	freq=$rdist_normal(uniqueseed,50,50);
end
////////////////////////////////////////////////////////
// variability model    							   //
////////////////////////////////////////////////////////

@(cross(V(OE,AE) - 1.5e-5, +1))
begin
	rold=rvar;
	lold=lvar;
	Nold=Nreal;
end

@(cross(V(AE,OE) - 1.5e-5, +1))
begin
	rold=rvar;
	lold=lvar;
	Nold=Nreal;
end

if (V(AE,OE)<-2e-5) //SET at negative voltage
	begin
		rvar=rold+(rnew-rold)*((Nreal-Nold)/(Ndiscmax-Nold)); // Equation 21
		lvar=lold+(lnew-lold)*((Nreal-Nold)/(Ndiscmax-Nold)); // Equation 22

	end
else if (V(AE,OE)>2e-5)	//RESET at positive voltage
	begin
		rvar=rold+(rnew-rold)*((Nold-Nreal)/(Nold-Ndiscmin)); // Equation 23
		lvar=lold+(lnew-lold)*((Nold-Nreal)/(Nold-Ndiscmin)); // Equation 24
	end
else
	begin
	end

////////////////////////////////////////////////////////
// auxiliary variables							   //
////////////////////////////////////////////////////////
A =`M_PI*pow(rvar,2); // cross sectional filament area

////////////////////////////////////////////////////////
// equivalent circuit diagramm 					   //
////////////////////////////////////////////////////////

// local temperature in the filament
Pwr(ith_branch)<+-(V(schottky)+V(discplugserial)*(Rdisc+Rplug)/(Rdisc+Rplug+Rseries))*I(schottky);	// Equation 5
Pwr(rth_branch) <+ Temp(rth_branch)/Rtheff;
Pwr(rth_branch) <+ ddt(Temp(rth_branch)*cth);
Treal = $temperature+Temp(rth_branch);		// Equation 5

//Schottkydiode,tunnel
if (V(schottky)<phibn0-phin)
	begin
		psi=phibn0-phin-V(schottky);
		phibn=phibn0-sqrt(sqrt(pow(`P_Q,3)*zvo*Nreal*1e26*psi/(8*pow(`M_PI,2)*(pow(epsphib_eff,3)))));	// Equation 19
		if (phibn<0)
			begin
				phibn=0;
			end
	end
else
	begin
		psi=0;
		phibn=phibn0;
	end

if (V(schottky)<0) //TFE Schottky SET direction
	begin
		W00=(`P_Q*`P_H/(4*`M_PI))*sqrt(zvo*Nreal*1e26/(mdiel*eps_eff));  // Equation 16
		W0=W00/tanh(W00/(`P_K*Treal));	// Equation 17
		epsprime=W00/(W00/(`P_K*Treal)-tanh(W00/(`P_K*Treal)));  // Equation 18
		Ischottkytunnel=-A*Arichardson*Treal/`P_K*sqrt(`M_PI*W00*`P_Q*(abs(V(schottky))+phibn/pow(cosh(W00/(`P_K*Treal)),2)))*exp(-`P_Q*phibn/W0)*(exp(`P_Q*abs(V(schottky))/epsprime)-1);  // Equation 14
	end
else		//Schottkydiode TE 	RESET direction
	begin
		Ischottkytunnel= A*Arichardson*pow(Treal,2)*exp(-phibn*`P_Q/(`P_K*Treal))*(exp(`P_Q/(`P_K*Treal)*V(schottky))-1); // Equation 15
	end
I(schottky) <+ Ischottkytunnel;

Rdisc=lvar*1e-9/(Nreal*1e26*zvo*`P_Q*un*A);	// Equation 13
Rplug=((lcell-lvar)*1e-9/(Nplug*1e26*zvo*`P_Q*un*A));	// Equation 13
Rseries=RTiOx+R0*(1+R0*alphaline*pow(I(discplugserial),2)*Rthline);	// Equation 12

V(discplugserial)<+(Rdisc+Rplug+Rseries)*I(discplugserial);

////////////////////////////////////////////////////////
// Solve ODE 									   //
////////////////////////////////////////////////////////

///Calculation of concentration
Nchange=idt(-1/(A*lvar*1e-9*`P_Q*zvo)*V(ion,gnd)/1e26,0);	// Equation 1

@(timer(0,1/freq)) // start, period (should fit to large jumps from experiments)
begin
		jump=0;	// cell is randomly initialised with -2 -1 0 1 or 2
		randnum_jump = abs($random() % 1000); //0.0001-0.9999
		p_jump = randnum_jump/1000;
	if (jump_old == -2)
		begin
		numberminustwos=numberminustwos+1;
	 		if (p_jump < p1)
				jump = -2;
			else
				jump = -1;
	 	end
	else if (jump_old == -1)
		begin
		numberminusones=numberminusones+1;
			if (p_jump < p1)
				jump = -2;
			else if (p_jump < p3)
				jump = -1;
			else
				jump = 0;
		 end
	else if (jump_old == 0)
		begin
		numberzeros=numberzeros+1;
			if (p_jump < p2)
	 	    		begin
					randnum_jump2 = abs($random() % 1000);
					p_jump_2 = randnum_jump2/1000;
					if (p_jump_2 > 0.5)
						jump = -1;
					else
						jump = 1;
				end
			else
				jump = 0;
		end
	else if (jump_old == 1)
		begin
		numberplusones=numberplusones+1;
			if (p_jump < p1)
				jump = 2;
			else if (p_jump < p3)
				jump = 1;
			else
				jump = 0;
		end
	else if (jump_old == 2)
		begin
		numberplustwos=numberplustwos+1;
			if (p_jump < p1)
				jump = 2;
			else
				jump = 1;
		end

	jump_old=jump;
	Nnoise_change = jump/(A*lnew*1e-9*1e26);

	if ((Ninit + Nnoise_change + Nchange<Ndiscmin)&(Nnoise_change<0))
		begin
			Nnoise_change=0;
		end
	else
		begin
		end
end

Nreal = Ninit + Nchange + Nnoise_change;

//I_ion is realised through a voltage source here
if (((Nreal<Ndiscmin)&(V(AE,OE)>0))|((Nreal>Ndiscmax)&(V(AE,OE)<0)))	// keep concentration Nreal in the borders of Ndiscmin and Ndiscmax
	begin
		V(ion,gnd)<+0;
	end
else
	begin
		cvo = (Nplug+Nreal)/2*1e26; // Equation 3
		if (V(AE,OE)>0)
			begin
				E_ion=(V(schottky)+V(discplugserial)*(Rdisc+Rplug)/(Rdisc+Rplug+Rseries))/(lcell*1e-9); // Equation 11 ERESET
				Rtheff = Rth0*pow(rdet/rvar,2)*Rtheff_scaling; // Equation 5 times scaling constant for RESET
				Flim=1-pow(Ndiscmin/Nreal,10);  // Equation 4
			end
		else
			begin
				E_ion=V(discplugserial)*Rdisc/(Rdisc+Rplug+Rseries)/(lvar*1e-9); // Equation 10 ESET
				Rtheff = Rth0*pow(rdet/rvar,2);  // Equation 6
				Flim=1-pow(Nreal/Ndiscmax,10);  // Equation 4
			end
		gamma=zvo*`P_Q*E_ion*a/(`M_PI*dWa*`P_Q);	// Equation 9
		dWamin=dWa*`P_Q*(sqrt(1-pow(gamma,2))-gamma*`M_PI/2+gamma*asin(gamma)); // Equation 7
		dWamax=dWa*`P_Q*(sqrt(1-pow(gamma,2))+gamma*`M_PI/2+gamma*asin(gamma)); // Equation 8
		V(ion,gnd)<+zvo*`P_Q*cvo*a*nyo*A*(exp(-dWamin/(`P_K*Treal))-exp(-dWamax/(`P_K*Treal)))*Flim; // Equation 2
	end
end
endmodule
